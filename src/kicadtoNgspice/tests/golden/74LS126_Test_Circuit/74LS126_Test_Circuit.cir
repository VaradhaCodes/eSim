* 74LS126_Test_Circuit (eSim netlist via kicad-cli kicadxml)
* Sheet Name: /
r1 gnd 1y 10k
r2 gnd 2y 10k
v1 net__x1_vcc gnd 5
v_1a1 1a gnd DC
v_1g1 1g gnd DC
v_2a1 2a gnd DC
v_2g1 2g gnd DC
x1 1g 1a 1y 2g 2a 2y gnd unconnected__x1_3y_pad8 unconnected__x1_3a_pad9 unconnected__x1_3g_pad10 unconnected__x1_4y_pad11 unconnected__x1_4a_pad12 unconnected__x1_4g_pad13 net__x1_vcc 74LS126
.end
