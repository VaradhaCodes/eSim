* D:\fossee\eSim\library\SubcircuitLibrary\counter\counter.cir

* EESchema Netlist Version 1.1 (Spice format) creation date: 04/11/26 08:48:43

* To exclude a component from the Spice Netlist add [Spice_Netlist_Enabled] user FIELD set to: N
* To reorder the component spice node sequence add [Spice_Node_Sequence] user FIELD and define sequence: 2,1,0

* Sheet Name: /
U3  Net-_U3-Pad1_ Net-_U1-Pad1_ Net-_U2-Pad2_ Net-_U3-Pad4_ Net-_U1-Pad2_ Net-_U3-Pad1_ d_dff
U4  GND Net-_U3-Pad4_ adc_bridge_1
U2  GND Net-_U2-Pad2_ adc_bridge_1
U6  Net-_U6-Pad1_ Net-_U1-Pad2_ Net-_U5-Pad2_ Net-_U6-Pad4_ Net-_U1-Pad3_ Net-_U6-Pad1_ d_dff
U7  GND Net-_U6-Pad4_ adc_bridge_1
U5  GND Net-_U5-Pad2_ adc_bridge_1
U9  Net-_U9-Pad1_ Net-_U1-Pad3_ Net-_U8-Pad2_ Net-_U10-Pad2_ Net-_U1-Pad4_ Net-_U9-Pad1_ d_dff
U10  GND Net-_U10-Pad2_ adc_bridge_1
U8  GND Net-_U8-Pad2_ adc_bridge_1
U12  Net-_U12-Pad1_ Net-_U1-Pad4_ Net-_U11-Pad2_ Net-_U12-Pad4_ Net-_U1-Pad5_ Net-_U12-Pad1_ d_dff
U13  GND Net-_U12-Pad4_ adc_bridge_1
U11  GND Net-_U11-Pad2_ adc_bridge_1
U1  Net-_U1-Pad1_ Net-_U1-Pad2_ Net-_U1-Pad3_ Net-_U1-Pad4_ Net-_U1-Pad5_ PORT

.end
