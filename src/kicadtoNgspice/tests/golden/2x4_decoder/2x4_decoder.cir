* C:\FOSSEE\eSim\src\SubcircuitLibrary\2x4_decoder\2x4_decoder.cir

* EESchema Netlist Version 1.1 (Spice format) creation date: 28-Sep-21 09:04:08

* To exclude a component from the Spice Netlist add [Spice_Netlist_Enabled] user FIELD set to: N
* To reorder the component spice node sequence add [Spice_Node_Sequence] user FIELD and define sequence: 2,1,0

* Sheet Name: /
U2  Net-_U1-Pad1_ Net-_U2-Pad2_ d_inverter
U3  Net-_U1-Pad2_ Net-_U3-Pad2_ d_inverter
X1  Net-_U2-Pad2_ Net-_U3-Pad2_ Net-_U1-Pad3_ Net-_U1-Pad4_ 3_and
X2  Net-_U3-Pad2_ Net-_U1-Pad1_ Net-_U1-Pad3_ Net-_U1-Pad5_ 3_and
X3  Net-_U2-Pad2_ Net-_U1-Pad2_ Net-_U1-Pad3_ Net-_U1-Pad6_ 3_and
X4  Net-_U1-Pad1_ Net-_U1-Pad2_ Net-_U1-Pad3_ Net-_U1-Pad7_ 3_and
U1  Net-_U1-Pad1_ Net-_U1-Pad2_ Net-_U1-Pad3_ Net-_U1-Pad4_ Net-_U1-Pad5_ Net-_U1-Pad6_ Net-_U1-Pad7_ PORT

.end
