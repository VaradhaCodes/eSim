* 74HC386_Test_Circuit (eSim netlist via kicad-cli kicadxml)
* Sheet Name: /
r1 gnd v_1y 1k
r2 gnd v_2y 1k
u1 v_1a plot_v1
u2 v_1b plot_v1
u3 v_2a plot_v1
u4 v_2b plot_v1
u5 v_1a v_1b v_2a v_2b net__u5_out1 net__u5_out2 net__u5_out3 net__u5_out4 adc_bridge_4
u6 v_1y plot_v1
u7 net__u7_in1 net__u7_in2 v_2y v_1y dac_bridge_2
u8 v_2y plot_v1
v1 net__x1_vcc gnd 5
v_1a1 v_1a gnd DC
v_1b1 v_1b gnd DC
v_2a1 v_2a gnd DC
v_2b1 v_2b gnd DC
x1 net__u5_out1 net__u5_out2 net__u7_in2 net__u7_in1 net__u5_out3 net__u5_out4 gnd unconnected__x1_3a_pad8 unconnected__x1_3b_pad9 unconnected__x1_3y_pad10 unconnected__x1_4y_pad11 unconnected__x1_4a_pad12 unconnected__x1_4b_pad13 net__x1_vcc 74HC386
.end
