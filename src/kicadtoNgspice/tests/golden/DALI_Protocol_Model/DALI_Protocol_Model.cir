* D:\esim\DALI_Protocol_Model\DALI_Protocol_Model.cir

* EESchema Netlist Version 1.1 (Spice format) creation date: 04/12/26 02:35:43

* To exclude a component from the Spice Netlist add [Spice_Netlist_Enabled] user FIELD set to: N
* To reorder the component spice node sequence add [Spice_Node_Sequence] user FIELD and define sequence: 2,1,0

* Sheet Name: /
Q1  DALI_Bus_Out Net-_Q1-Pad2_ GND eSim_NPN
R2  Net-_Q1-Pad2_ Tx_Digital_In 1k
R1  DALI_Bus_Out Net-_R1-Pad2_ 4.7k
v1  Net-_R1-Pad2_ GND 16
Q2  Rx_Digital_Out Net-_Q2-Pad2_ GND eSim_NPN
R4  DALI_Bus_Out Net-_Q2-Pad2_ 10k
R3  Net-_R3-Pad1_ Rx_Digital_Out 4.7k
v3  Net-_R3-Pad1_ GND 5
U1  Tx_Digital_In Net-_U1-Pad2_ adc_bridge_1
U4  Net-_U3-Pad3_ Net-_R5-Pad2_ dac_bridge_1
v4  Net-_U2-Pad1_ GND 5
U2  Net-_U2-Pad1_ Net-_U2-Pad2_ adc_bridge_1
v2  Tx_Digital_In GND PULSE(0 5 0 1u 1u 416u 833u)
U3  Net-_U1-Pad2_ Net-_U2-Pad2_ Net-_U3-Pad3_ d_xor
R5  Tx_Digital_In Net-_R5-Pad2_ 100k

.end
