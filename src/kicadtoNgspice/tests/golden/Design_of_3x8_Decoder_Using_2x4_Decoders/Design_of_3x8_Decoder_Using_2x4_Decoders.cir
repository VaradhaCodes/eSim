* C:\Users\hp\Desktop\Esim\Design_of_3x8_Decoder_Using_2x4_Decoders\Design_of_3x8_Decoder_Using_2x4_Decoders.cir

* EESchema Netlist Version 1.1 (Spice format) creation date: 28-Sep-21 09:08:12

* To exclude a component from the Spice Netlist add [Spice_Netlist_Enabled] user FIELD set to: N
* To reorder the component spice node sequence add [Spice_Node_Sequence] user FIELD and define sequence: 2,1,0

* Sheet Name: /
U6  Net-_U6-Pad1_ Net-_U6-Pad2_ Net-_U6-Pad3_ Net-_U6-Pad4_ Net-_U6-Pad5_ Net-_U6-Pad6_ Net-_U6-Pad7_ Net-_U6-Pad8_ D0 D1 D2 D3 D4 D5 D6 D7 dac_bridge_8
v1  A GND pulse
v2  B GND pulse
v3  C GND pulse
R1  D7 GND 1k
R2  D6 GND 1k
R3  D5 GND 1k
R4  D4 GND 1k
R5  D3 GND 1k
R6  D2 GND 1k
R7  D1 GND 1k
R8  D0 GND 1k
U4  A B C Net-_U4-Pad4_ Net-_U4-Pad5_ Net-_U4-Pad6_ adc_bridge_3
U5  Net-_U4-Pad6_ Net-_U5-Pad2_ d_inverter
U1  A plot_v1
U2  B plot_v1
U3  C plot_v1
U14  D7 plot_v1
U13  D6 plot_v1
U12  D5 plot_v1
U11  D4 plot_v1
U10  D3 plot_v1
U9  D2 plot_v1
U8  D1 plot_v1
U7  D0 plot_v1
X1  Net-_U4-Pad4_ Net-_U4-Pad5_ Net-_U5-Pad2_ Net-_U6-Pad1_ Net-_U6-Pad2_ Net-_U6-Pad3_ Net-_U6-Pad4_ 2x4_decoder_subcircuit
X2  Net-_U4-Pad4_ Net-_U4-Pad5_ Net-_U4-Pad6_ Net-_U6-Pad5_ Net-_U6-Pad6_ Net-_U6-Pad7_ Net-_U6-Pad8_ 2x4_decoder_subcircuit

.end
