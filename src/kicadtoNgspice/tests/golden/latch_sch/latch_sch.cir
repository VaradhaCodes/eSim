* D:\fossee\eSim\library\SubcircuitLibrary\latch_sch\latch_sch.cir

* EESchema Netlist Version 1.1 (Spice format) creation date: 04/11/26 11:49:12

* To exclude a component from the Spice Netlist add [Spice_Netlist_Enabled] user FIELD set to: N
* To reorder the component spice node sequence add [Spice_Node_Sequence] user FIELD and define sequence: 2,1,0

* Sheet Name: /
U2  Net-_U1-Pad2_ Net-_U1-Pad1_ Net-_U2-Pad3_ Net-_U2-Pad4_ Net-_U1-Pad3_ ? d_dlatch
U3  GND Net-_U2-Pad3_ adc_bridge_1
U4  GND Net-_U2-Pad4_ adc_bridge_1
U1  Net-_U1-Pad1_ Net-_U1-Pad2_ Net-_U1-Pad3_ PORT

.end
