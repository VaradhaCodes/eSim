* 4-Tap_MovingAverageFilter (eSim netlist via kicad-cli kicadxml)
* Sheet Name: /
u1 net__u1_clk0 net__u1_reset0 net__u1_data_in7 net__u1_data_in6 net__u1_data_in5 net__u1_data_in4 net__u1_data_in3 net__u1_data_in2 net__u1_data_in1 net__u1_data_in0 net__u1_data_out7 net__u1_data_out6 net__u1_data_out5 net__u1_data_out4 net__u1_data_out3 net__u1_data_out2 net__u1_data_out1 net__u1_data_out0 moving_average_4tap
u2 net__u2_in1 net__u1_reset0 adc_bridge_1
u3 net__u3_in1 net__u1_clk0 adc_bridge_1
u4 out_3 plot_v1
u5 gnd gnd gnd net__u5_in4 gnd gnd gnd gnd net__u1_data_in7 net__u1_data_in6 net__u1_data_in5 net__u1_data_in4 net__u1_data_in3 net__u1_data_in2 net__u1_data_in1 net__u1_data_in0 adc_bridge_8
u6 net__u1_data_out7 net__u1_data_out6 net__u1_data_out5 net__u1_data_out4 net__u1_data_out3 net__u1_data_out2 net__u1_data_out1 net__u1_data_out0 out_1 out_2 out_3 out_4 out_5 out_6 out_7 out_8 dac_bridge_8
u7 out_1 plot_v1
u8 out_2 plot_v1
u9 out_8 plot_v1
u10 out_4 plot_v1
u11 out_5 plot_v1
u12 out_6 plot_v1
u13 out_7 plot_v1
v1 net__u2_in1 gnd pulse
v2 net__u3_in1 gnd pulse
v4 net__u5_in4 gnd pulse
.end
