* C:\Users\hp\eSim-Workspace\transimp2\transimp2.cir

* EESchema Netlist Version 1.1 (Spice format) creation date: 2/9/2026 9:21:04 PM

* To exclude a component from the Spice Netlist add [Spice_Netlist_Enabled] user FIELD set to: N
* To reorder the component spice node sequence add [Spice_Node_Sequence] user FIELD and define sequence: 2,1,0

* Sheet Name: /
M7  vbias1 vbias1 Vdd Vdd eSim_MOS_P
M6  vbias1 vbias1 GND GND eSim_MOS_N
M5  Net-_M3-Pad3_ vbias1 Vdd Vdd eSim_MOS_P
M4  vout1 Net-_M4-Pad2_ Net-_M3-Pad3_ Vdd eSim_MOS_P
M1  Net-_M1-Pad1_ Net-_M1-Pad1_ GND GND eSim_MOS_N
M2  vout1 Net-_M1-Pad1_ GND GND eSim_MOS_N
R1  Net-_M4-Pad2_ vout1 34K
M18  vbias3 vbias3 Vdd Vdd eSim_MOS_P
M17  vbias3 vbias3 GND GND eSim_MOS_N
R2  Net-_M4-Pad2_ Net-_R2-Pad2_ 1Meg
v2  Net-_R2-Pad2_ GND AC
v1  Vdd GND 5V
M11  Net-_M10-Pad3_ vbias3 GND GND eSim_MOS_N
M9  Net-_M14-Pad1_ vbias2 Net-_M10-Pad3_ GND eSim_MOS_N
M10  vout3 vout1 Net-_M10-Pad3_ GND eSim_MOS_N
M16  vbias2 vbias2 Vdd Vdd eSim_MOS_P
M8  vbias2 vbias2 GND GND eSim_MOS_N
M14  Net-_M14-Pad1_ Net-_M14-Pad1_ Vdd Vdd eSim_MOS_P
M15  vout3 Net-_M14-Pad1_ Vdd Vdd eSim_MOS_P
M3  Net-_M1-Pad1_ vbias2 Net-_M3-Pad3_ Vdd eSim_MOS_P
M13  Vdd vout3 vout4 GND eSim_MOS_N
M12  vout4 vbias3 GND GND eSim_MOS_N

.end
