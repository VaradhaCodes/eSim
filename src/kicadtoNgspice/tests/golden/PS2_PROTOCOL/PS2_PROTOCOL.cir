* C:\FOSSEE\Projects\Esim_Tutorials\PS2_PROTOCOL\PS2_PROTOCOL.cir

* EESchema Netlist Version 1.1 (Spice format) creation date: 04/12/26 19:27:11

* To exclude a component from the Spice Netlist add [Spice_Netlist_Enabled] user FIELD set to: N
* To reorder the component spice node sequence add [Spice_Node_Sequence] user FIELD and define sequence: 2,1,0

* Sheet Name: /
R1  Net-_R1-Pad1_ CLK_LINE 4.7k
R2  Net-_R1-Pad1_ DATA_LINE 4.7k
M2  DATA_LINE DATA GND GND mosfet_n
M1  CLK_LINE CLK GND GND mosfet_n
v1  Net-_R1-Pad1_ GND 5v
U1  CLK plot_v1
U4  DATA_LINE plot_v1
v2  CLK GND pulse
v3  DATA GND pwl
U3  DATA plot_v1
U2  CLK_LINE plot_v1

.end
