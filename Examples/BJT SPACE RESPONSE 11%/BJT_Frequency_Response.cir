.title KiCad schematic
v1 __v1
U3 __U3
U2 __U2
C3 out Net-_Q1-C_ 40u
R5 Net-_Q1-C_ Net-_v1-+_ 2k
Q1 __Q1
R2 Net-_Q1-B_ Net-_v1-+_ 200k
R3 GND Net-_Q1-B_ 50k
C1 Net-_C1-Pad1_ Net-_Q1-B_ 40u
R1 in Net-_C1-Pad1_ 50
U1 __U1
v2 __v2
R6 GND out 1k
R4 GND Net-_Q1-E_ 1.5k
C2 GND Net-_Q1-E_ 100u
.end
