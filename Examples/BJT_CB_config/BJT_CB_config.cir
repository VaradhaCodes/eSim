.title KiCad schematic
.model __Q1 NPN level=8
R1 Net-_U_ic1--_ Net-_Q1-C_ 1k
Q1 Net-_Q1-C_ GND Net-_Q1-E_ NC-Q1-0 NC-Q1-1 __Q1
Vv1 vcb GND DC V
R2 Net-_Q1-E_ ie 1k
I1 ie GND DC dc
.end
