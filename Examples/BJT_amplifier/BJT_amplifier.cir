.title KiCad schematic
.model __Q1 NMF
R6 out GND 1k
C3 out Net-_Q1-C_ 40u
R4 Net-_Q1-E_ GND 1.5k
C2 GND Net-_Q1-E_ 100u
R3 Net-_Q1-B_ GND 50k
C1 Net-_C1-Pad1_ Net-_Q1-B_ 40u
R1 Net-_C1-Pad1_ in 50
Vv2 in GND DC 0 SIN( 0 1 )
R2 Net-_v1-+_ Net-_Q1-B_ 200k
R5 Net-_v1-+_ Net-_Q1-C_ 2k
Vv1 Net-_v1-+_ GND
ZQ1 Net-_Q1-C_ Net-_Q1-B_ Net-_Q1-E_ __Q1
.end
